# Ansys Electronics Desktop project, version 2023.1
materials:
  Rogers RT/duroid 5880 (tm): permittivity=2.2 dielectric_loss_tangent=0.0009
  Teflon (tm): permittivity=2.1 dielectric_loss_tangent=0.001
  pec: conductivity=1e+30
  vacuum: permittivity=1

design HFSSDesign (HFSS, HFSS Modal Network, model units mm)
options: Allow_Material_Override
geometry:
  ground, p1, feed [pec] = imported_body(E:\sagar\microstrip\cp\s1.step)
  die [Teflon (tm)] = imported_body(E:\sagar\microstrip\cp\s1.step)
  coax, pecCap1 [pec] = imported_body(E:\sagar\microstrip\cp\s1.step)
  RadiatingSurface [vacuum] = region(absolute_offset=8.2644628mm on all sides)
  group s1 = ground, p1, feed, die, coax, pecCap1
boundaries and excitations:
  Open1: Radiation Objects=RadiatingSurface
  1: Wave Port Faces=die.face(at (54.22, 1, -7)) WavePortType=Modal NumModes=1 Modes{Mode1{IntLine{(54.86, 1, -7) -> (56.25, 1, -7)} CharImp=Zpi}}
setups:
  Setup1: HfssDriven Frequency=12.1GHz MaxDeltaS=0.01 MaximumPasses=20 MinimumPasses=1 MinimumConvergedPasses=1 PercentRefinement=30 BasisOrder=1 PortAccuracy=2 DrivenSolverType="Direct Solver" SaveRadFieldsOnly
    sweep Sweep: 12GHz to 12.3GHz step 0.1GHz; Type=Discrete SaveFields SaveRadFields
source amplitudes:
  1:1: 1W 0deg
radiation setups:
  3D: Infinite Sphere Theta=0deg..180deg step 2deg Phi=-180deg..180deg step 2deg
  Elevation: Infinite Sphere Theta=-180deg..180deg step 1deg Phi=0deg..90deg step 90deg
  Azimuth: Infinite Sphere Theta=90deg..90deg step 0deg Phi=-180deg..180deg step 1deg
reports:
  Realized Gain Plot 1: dB(RealizedGainTotal) vs Theta on Setup1 : LastAdaptive, Elevation [Phi=all Freq=12.1GHz]
  Realized Gain Plot 2: dB(RealizedGainLHCP), dB(RealizedGainRHCP) vs Theta on Setup1 : LastAdaptive, Elevation [Phi=all Freq=12.1GHz]
  Axial Ratio Plot 1: dB(AxialRatioValue) vs Freq on Setup1 : Sweep, Elevation [Phi=all Theta=0deg]
  VSWR Plot 1: VSWR(1), VSWR(2), VSWR(3), VSWR(4), VSWR(5), VSWR(6), VSWR(7), VSWR(8) vs Freq on Setup1 : Sweep
  Realized Gain Plot 3: dB(RealizedGainTotal) vs Freq on Setup1 : Sweep, Elevation [Phi=all Theta=0deg]
  S Parameter Plot 1: dB(S(1,1)) vs Freq on Setup1 : Sweep
  S Parameter Plot 2: dB(S(1,1)) vs Freq on Setup1 : Sweep
  Axial Ratio Plot 2: dB(AxialRatioValue) vs Freq on Setup1 : Sweep, Elevation [Phi=all Theta=0deg]
